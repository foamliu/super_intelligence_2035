* CDL netlist for T_IsmTop (IsmRCC extraction target)
* Generated by emy2netlist  Version 2025.09.sp1.hf6
* Process: imc19n_LP_RW  ;  VDD=0.72  ;  corner TYP_98
*==================================================
.SUBCKT invLx1 A Y vbn! vbp! vcc! vss!
*.PININFO A:I Y:O vbn!:B vbp!:B vcc!:B vss!:B
XMP0 Y A vcc! vbp! / PMOS_LX1
XMN0 Y A vss! vbn! / NMOS_LX1
.ENDS

.SUBCKT nand2Lx1 A B Y vbn! vbp! vcc! vss!
*.PININFO A:I B:I Y:O vbn!:B vbp!:B vcc!:B vss!:B
XMP1 Y A net01 vbp! / PMOS_LX2
XMP2 net01 B vcc! vbp! / PMOS_LX2
XMN1 Y A vss! vbn! / NMOS_LX2
XMN2 Y B vss! vbn! / NMOS_LX2
.ENDS

.SUBCKT nor2Lx1 A B Y vbn! vbp! vcc! vss!
*.PININFO A:I B:I Y:O vbn!:B vbp!:B vcc!:B vss!:B
XMP1 Y A vcc! vbp! / PMOS_LX2
XMP2 Y B vcc! vbp! / PMOS_LX2
XMN1 net01 A vss! vbn! / NMOS_LX2
XMN2 Y B net01 vbn! / NMOS_LX2
.ENDS

.SUBCKT and2Lx2 A B Y vbn! vbp! vcc! vss!
*.PININFO A:I B:I Y:O vbn!:B vbp!:B vcc!:B vss!:B
XN1 net01 A B vbn! vbp! vcc! vss! / nand2Lx1
XI0 net01 Y vbn! vbp! vcc! vss! / invLx1
.ENDS

.SUBCKT bufLx4 A Y vbn! vbp! vcc! vss!
*.PININFO A:I Y:O vbn!:B vbp!:B vcc!:B vss!:B
XI1 netA Y vbn! vbp! vcc! vss! / invLx4
XI0 A netA vbn! vbp! vcc! vss! / invLx4
.ENDS

.SUBCKT bufLx16 A Y vbn! vbp! vcc! vss!
*.PININFO A:I Y:O vbn!:B vbp!:B vcc!:B vss!:B
XI3 netB Y vbn! vbp! vcc! vss! / invLx16
XI2 netA netB vbn! vbp! vcc! vss! / invLx16
XI1 netC netA vbn! vbp! vcc! vss! / invLx16
XI0 A netC vbn! vbp! vcc! vss! / invLx16
.ENDS

*==================================================
* Top cell
*==================================================
.SUBCKT T_IsmTop IsmIn<7:0> IsmOut<7:0> vbn! vbp! vcc! vdbias! vss!
*.PININFO IsmIn<7:0>:I IsmOut<7:0>:O vbn!:B vbp!:B vcc!:B vdbias!:B vss!:B
XI312 net123 LastPlsCnt<0> net0 vss! vcc! vcc! vss! / and2Lx2
XI335 fnIsmSel543N<7> fnIsmSel210N<3> fnIsmDlySel59 vss! vcc! vcc! vss! / nor2Lx1
XI333 fnIsmSel543N<4> fnIsmSel210N<7> fnIsmDlySel39 vss! vcc! vcc! vss! / nor2Lx1
XI340 fnIsmSel543N<5> fnIsmSel210N<2> fnIsmDlySel42 vss! vcc! vcc! vss! / nor2Lx1
XI378 JudgeN<6> JudgeN_buff6 vss! vcc! vcc! vss! / bufLx4
XI39 JudgeN<1> JudgeN_buff1 vss! vcc! vcc! vss! / bufLx4
XI37 JudgeN<8> JudgeN_buff vbn! vbp! vcc! vss! / bufLx4
XI40 DlySel<0> DlySel_b vss! vcc! vcc! vss! / bufLx4
XI51 DlySel<3> DlySel_b3 vss! vcc! vcc! vss! / bufLx16
XI376 fnIsmCntClkGen net_clk vss! vcc! vcc! vss! / invLx1
.ENDS T_IsmTop
